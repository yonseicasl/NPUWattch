* ============================================================
* Testbench: @CELLNAME@ Write Driver — @NODE@ FinFET  VDD = @VDD@V
* Simulator:  HSPICE / PrimeSim
* Generated by run_wd.sh — do not edit directly; edit lib/tb_wd_template.sp
* ============================================================
* Write driver sequence:
*   0ns  — data=0  write=0  (idle, BL/BL_bar pre-charged)
*  10ns  — write=1           (enable write, data=0 -> BL down, BL_bar up)
*  20ns  — data=1            (data flips  -> BL up,   BL_bar down)
*  30ns  — data=0            (data flips  -> BL down, BL_bar up)
*  40ns  — write=0           (write disabled, BL lines float)
*  50ns  — end
* ============================================================

.title @CELLNAME@ Write Driver Test (@NODE@)

* ── Node model cards (aliased nmos1/pmos1 for the extracted netlist).
*    The line below becomes .hdl '<verilog-a file>' when the node's node.env
*    sets MODEL_HDL (BSIM-CMG at 5nm); native level=72 cards need no .hdl. ────
@HDL_LINE@
.include './models/nmos1.inc'
.include './models/pmos1.inc'

* ── Cell netlist (port order parsed from the extracted .SUBCKT) ──────────
.include './@CELLNAME@.sp'

* ── Power supplies ────────────────────────────────────────────────────────
VVDD VDD 0 @VDD@
VVSS VSS 0 0

* ── write: 0->VDD at 10ns, VDD->0 at 40ns ───────────────────────────────
Vwrite write 0 PWL(
+  0n     0
+ 10n     0
+ 10.01n  @VDD@
+ 40n     @VDD@
+ 40.01n  0
+ 50n     0 )

* ── data: 0->VDD at 20ns, VDD->0 at 30ns ───────────────────────────────
Vdata data 0 PWL(
+  0n     0
+ 20n     0
+ 20.01n  @VDD@
+ 30n     @VDD@
+ 30.01n  0
+ 50n     0 )

* ── Bitline load capacitance (short-column estimate; set per node in node.env)
CBL    BL     0 @BL_CAP@
CBLbar BL_bar 0 @BL_CAP@

* ── Initial conditions: bitlines pre-charged to VDD ─────────────────────
.ic v(BL)=@VDD@ v(BL_bar)=@VDD@

* ── DUT instantiation (TB nets listed in the cell's own port order;
*    BLB-style cell port names map onto the canonical TB nets) ────────────
Xdut @XDUT_PORTS@ @CELLNAME@

* ── Transient analysis: 1ps step, 50ns total ─────────────────────────────
.tran 1p 50n

* ── Probe waveforms ──────────────────────────────────────────────────────
.probe tran v(BL) v(BL_bar) v(data) v(write) v(VDD)

* ── Measurements: supply energy per phase + BL swing timing ──────────────
.measure tran i_avg_write avg i(VVDD) from=10n to=40n
.measure tran q_write integ i(VVDD) from=10n to=40n
.measure tran t_bl_fall  trig v(write) val='@VDD@/2' rise=1
+                        targ v(BL)    val='@VDD@/2' fall=1
.measure tran t_bl_rise  trig v(data)  val='@VDD@/2' rise=1
+                        targ v(BL)    val='@VDD@/2' rise=1
.measure tran t_blb_fall trig v(data)   val='@VDD@/2' rise=1
+                        targ v(BL_bar) val='@VDD@/2' fall=1
.measure tran t_blb_rise trig v(data)   val='@VDD@/2' fall=1
+                        targ v(BL_bar) val='@VDD@/2' rise=1

* ── Functional check: BL = buffer(data), BL_bar = invert(data) while write=1
*    sampled with data=0 (15n), data=1 (29n), data=0 again (39n)
.measure tran v_bl_d0a  find v(BL)     at=15n  $ expect ~0
.measure tran v_blb_d0a find v(BL_bar) at=15n  $ expect ~VDD
.measure tran v_bl_d1   find v(BL)     at=29n  $ expect ~VDD
.measure tran v_blb_d1  find v(BL_bar) at=29n  $ expect ~0
.measure tran v_bl_d0b  find v(BL)     at=39n  $ expect ~0
.measure tran v_blb_d0b find v(BL_bar) at=39n  $ expect ~VDD

* ── Simulation options ───────────────────────────────────────────────────
.temp @TEMP@
@BA_LINE@
.option post ingold accurate numdgt=6

.end
